ADE simulation setup
Run mode: Single Run, Sweeps and Corners
Tests:
  BioZ_EMG_Model:BioZ_Comsol_TB:1: BioZ_EMG_Model/BioZ_Comsol_TB_2/schematic, simulator spectre
    Outputs: mag_comsol_arm_2cm; mag_diff1_arm_2cm; mag_cole_arm_2cm; pha_comsol_arm_2cm; pha_cole_arm_2cm; mag_diff3_arm_2cm; mag_diff4_arm_2cm; mag_diff5_arm_2cm; mag_diff2_arm_2cm; mag_diff1_arm_4cm; mag_diff2_arm_4cm; mag_diff3_arm_4cm; mag_diff4_arm_4cm; mag_diff5_arm_4cm; mag_diff1_leg_2cm; mag_diff2_leg_2cm; mag_diff3_leg_2cm; mag_diff4_leg_2cm; mag_diff5_leg_2cm; mag_diff1_leg_4cm; mag_diff2_leg_4cm; mag_diff3_leg_4cm; mag_diff4_leg_4cm; mag_diff5_leg_4cm; mag_comsol_arm_4cm; mag_cole_arm_4cm; pha_comsol_arm_4cm; pha_cole_arm_4cm; mag_comsol_leg_2cm; mag_cole_leg_2cm; pha_comsol_leg_2cm; pha_cole_leg_2cm; mag_comsol_leg_4cm; mag_cole_leg_4cm; pha_comsol_leg_4cm; pha_cole_leg_4cm
Global variables:
  a1_arm_2cm = 0.99
  a1_arm_4cm = 0.93
  a1_leg_2cm = 0.99
  a1_leg_4cm = 0.95
  a2_arm_2cm = 0.80
  a2_arm_4cm = 0.80
  a2_leg_2cm = 0.78
  a2_leg_4cm = 0.88
  a3_arm_2cm = 0.71
  a3_arm_4cm = 0.86
  a3_leg_2cm = 0.80
  a3_leg_4cm = 0.86
  R1_arm_2cm = 31
  R1_arm_4cm = 46
  R1_leg_2cm = 10
  R1_leg_4cm = 10.5
  R2_arm_2cm = 35
  R2_arm_4cm = 40
  R2_leg_2cm = 16
  R2_leg_4cm = 8.7
  R3_arm_2cm = 16
  R3_arm_4cm = 10
  R3_leg_2cm = 4
  R3_leg_4cm = 1.8
  Rinf_arm_2cm = 10
  Rinf_arm_4cm = 12
  Rinf_leg_2cm = 6
  Rinf_leg_4cm = 6
  Z1_arm_2cm = 7k
  Z1_arm_4cm = 9k
  Z1_leg_2cm = 1.8k
  Z1_leg_4cm = 2.4k
  Z2_arm_2cm = 1.5M
  Z2_arm_4cm = 1.6M
  Z2_leg_2cm = 600k
  Z2_leg_4cm = 1.7M
  Z3_arm_2cm = 17k
  Z3_arm_4cm = 20k
  Z3_leg_2cm = 13k
  Z3_leg_4cm = 6k
Device parameters (all switched off):
  BioZ_EMG_Model/BioZ_Comsol_TB/schematic/Rinf_arm_2cm.r = 5
  BioZ_EMG_Model/BioZ_Comsol_TB/schematic/R1_arm_2cm.r = 34
  BioZ_EMG_Model/BioZ_Comsol_TB/schematic/R2_arm_2cm.r = 46
  BioZ_EMG_Model/BioZ_Comsol_TB/schematic/R3_arm_2cm.r = 8
  BioZ_EMG_Model/BioZ_Comsol_TB/schematic/Rinf_arm_4cm.r = 6
  BioZ_EMG_Model/BioZ_Comsol_TB/schematic/R1_arm_4cm.r = 50
  BioZ_EMG_Model/BioZ_Comsol_TB/schematic/R2_arm_4cm.r = 46
  BioZ_EMG_Model/BioZ_Comsol_TB/schematic/R3_arm_4cm.r = 7
  BioZ_EMG_Model/BioZ_Comsol_TB/schematic/Rinf_leg_2cm.r = 3
  BioZ_EMG_Model/BioZ_Comsol_TB/schematic/R1_leg_2cm.r = 10
  BioZ_EMG_Model/BioZ_Comsol_TB/schematic/R2_leg_2cm.r = 20
  BioZ_EMG_Model/BioZ_Comsol_TB/schematic/R3_leg_2cm.r = 3
  BioZ_EMG_Model/BioZ_Comsol_TB/schematic/Rinf_leg_4cm.r = 4
  BioZ_EMG_Model/BioZ_Comsol_TB/schematic/R1_leg_4cm.r = 11
  BioZ_EMG_Model/BioZ_Comsol_TB/schematic/R2_leg_4cm.r = 10
  BioZ_EMG_Model/BioZ_Comsol_TB/schematic/R3_leg_4cm.r = 2
  BioZ_EMG_Model/BioZ_Comsol_TB/schematic/FP1_arm_2cm.coef = 6.5k
  BioZ_EMG_Model/BioZ_Comsol_TB/schematic/FP1_arm_2cm.slope = -0.95
  BioZ_EMG_Model/BioZ_Comsol_TB/schematic/FP2_arm_2cm.coef = 1.5M
  BioZ_EMG_Model/BioZ_Comsol_TB/schematic/FP2_arm_2cm.slope = -0.8
  BioZ_EMG_Model/BioZ_Comsol_TB/schematic/FP3_arm_2cm.coef = 70k
  BioZ_EMG_Model/BioZ_Comsol_TB/schematic/FP3_arm_2cm.slope = -0.9999
  BioZ_EMG_Model/BioZ_Comsol_TB/schematic/FP1_arm_4cm.coef = 9k
  BioZ_EMG_Model/BioZ_Comsol_TB/schematic/FP1_arm_4cm.slope = -0.91
  BioZ_EMG_Model/BioZ_Comsol_TB/schematic/FP2_arm_4cm.coef = 1.5M
  BioZ_EMG_Model/BioZ_Comsol_TB/schematic/FP2_arm_4cm.slope = -0.78
  BioZ_EMG_Model/BioZ_Comsol_TB/schematic/FP3_arm_4cm.coef = 70k
  BioZ_EMG_Model/BioZ_Comsol_TB/schematic/FP3_arm_4cm.slope = -0.9999
  BioZ_EMG_Model/BioZ_Comsol_TB/schematic/FP1_leg_2cm.coef = 1.6k
  BioZ_EMG_Model/BioZ_Comsol_TB/schematic/FP1_leg_2cm.slope = -0.97
  BioZ_EMG_Model/BioZ_Comsol_TB/schematic/FP2_leg_2cm.coef = 600k
  BioZ_EMG_Model/BioZ_Comsol_TB/schematic/FP2_leg_2cm.slope = -0.78
  BioZ_EMG_Model/BioZ_Comsol_TB/schematic/FP3_leg_2cm.coef = 15k
  BioZ_EMG_Model/BioZ_Comsol_TB/schematic/FP3_leg_2cm.slope = -0.84
  BioZ_EMG_Model/BioZ_Comsol_TB/schematic/FP1_leg_4cm.coef = 2.5k
  BioZ_EMG_Model/BioZ_Comsol_TB/schematic/FP1_leg_4cm.slope = -0.93
  BioZ_EMG_Model/BioZ_Comsol_TB/schematic/FP2_leg_4cm.coef = 1.7M
  BioZ_EMG_Model/BioZ_Comsol_TB/schematic/FP2_leg_4cm.slope = -0.86
  BioZ_EMG_Model/BioZ_Comsol_TB/schematic/FP3_leg_4cm.coef = 10k
  BioZ_EMG_Model/BioZ_Comsol_TB/schematic/FP3_leg_4cm.slope = -0.79
Specs:
  BioZ_EMG_Model:BioZ_Comsol_TB:1 / mag_diff5_arm_2cm: range -1 to 1
  BioZ_EMG_Model:BioZ_Comsol_TB:1 / mag_diff4_arm_2cm: range -1 to 1
  BioZ_EMG_Model:BioZ_Comsol_TB:1 / mag_diff3_arm_2cm: range -1 to 1
  BioZ_EMG_Model:BioZ_Comsol_TB:1 / mag_diff1_arm_2cm: range -1 to 1
  BioZ_EMG_Model:BioZ_Comsol_TB:1 / mag_diff2_arm_2cm: range -1 to 1
  BioZ_EMG_Model:BioZ_Comsol_TB:1 / mag_diff1_arm_4cm: range -1 to 1
  BioZ_EMG_Model:BioZ_Comsol_TB:1 / mag_diff2_arm_4cm: range -1 to 1
  BioZ_EMG_Model:BioZ_Comsol_TB:1 / mag_diff3_arm_4cm: range -1 to 1
  BioZ_EMG_Model:BioZ_Comsol_TB:1 / mag_diff4_arm_4cm: range -1 to 1
  BioZ_EMG_Model:BioZ_Comsol_TB:1 / mag_diff5_arm_4cm: range -1 to 1
  BioZ_EMG_Model:BioZ_Comsol_TB:1 / mag_diff1_leg_2cm: range -1 to 1
  BioZ_EMG_Model:BioZ_Comsol_TB:1 / mag_diff2_leg_2cm: range -1 to 1
  BioZ_EMG_Model:BioZ_Comsol_TB:1 / mag_diff3_leg_2cm: range -1 to 1
  BioZ_EMG_Model:BioZ_Comsol_TB:1 / mag_diff4_leg_2cm: range -1 to 1
  BioZ_EMG_Model:BioZ_Comsol_TB:1 / mag_diff5_leg_2cm: range -1 to 1
  BioZ_EMG_Model:BioZ_Comsol_TB:1 / mag_diff1_leg_4cm: range -1 to 1
  BioZ_EMG_Model:BioZ_Comsol_TB:1 / mag_diff2_leg_4cm: range -1 to 1
  BioZ_EMG_Model:BioZ_Comsol_TB:1 / mag_diff3_leg_4cm: range -1 to 1
  BioZ_EMG_Model:BioZ_Comsol_TB:1 / mag_diff4_leg_4cm: range -1 to 1
  BioZ_EMG_Model:BioZ_Comsol_TB:1 / mag_diff5_leg_4cm: range -1 to 1
Single Run, Sweeps and Corners options: submitpointsenabled=0
