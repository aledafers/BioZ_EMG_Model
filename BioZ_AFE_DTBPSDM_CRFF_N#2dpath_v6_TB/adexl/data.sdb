ADE simulation setup
Run mode: Single Run, Sweeps and Corners
Tests:
  BioZ_EMG_Model:BioZ_AFE_DTBPSDM_CRFF_N-path_v6_TB:1: BioZ_EMG_Model/BioZ_AFE_DTBPSDM_CRFF_N-path_v6_TB/config, simulator ams
    Outputs: VT(""); SDM_in; res1; res2; SDM_out; vdac; /sum1p; /sum1n; sum1; /compp; /compn; (VT("/sum1p") - VT("/sum1n")); comp; /a1; "/a2"; "/b1"; /b2; /a2; /b1; /c1; /c2; res3
Global variables:
  t_trans = 1m
  pi = 3.1416
  Voh = 1.8
  dBfs = -1
  vcm = 900m
  vpk = 0.9*10**(dBfs/20)
  fs = 62.5k
  f0 = fs/4
  fB = fs/(2*256)
  a1 = 1.0669
  a2 = 0.9777
  a3 = 1.3350
  b1 = 0.4891
  c1 = 0.4891
  c2 = 0.2660
  c3 = 0.0794
  Cf = 30p
  Ch = Cf/10
  Av1_dB = 71.39
  Av2_dB = 71.39
  Av3_dB = 71.39
  Av1 = 10**(Av1_dB/20)
  Av2 = 10**(Av2_dB/20)
  Av3 = 10**(Av3_dB/20)
  BW1 = fs/4
  BW2 = BW1
  BW3 = BW1
  GBW1 = Av1*BW1
  GBW2 = Av2*BW2
  GBW3 = Av3*BW3
  SR1 = 2*pi*GBW1*Voh
  SR2 = 2*pi*GBW2*Voh
  SR3 = 2*pi*GBW3*Voh
  cap_mismatch = 0
  tr = 20n
  tf = 20n
  Ron = 10
  Roff = 500M
  Rout_ac1 = 100
  Rout_ac2 = Rout_ac1
  Rout_ac3 = Rout_ac1
  wp2 = 750k
  wz = 9M
  cap_scale = 1
  Voffp_comp = 0
  Voffn_comp = 0
  tdelay_comp = 0
Single Run, Sweeps and Corners options: submitpointsenabled=0
