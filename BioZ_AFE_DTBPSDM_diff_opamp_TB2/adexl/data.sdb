ADE simulation setup
Run mode: Single Run, Sweeps and Corners
Tests:
  BioZ_EMG_Model:BioZ_AFE_DTBPSDM_diff_opamp_TB:1: BioZ_EMG_Model/BioZ_AFE_DTBPSDM_diff_opamp_TB2/config, simulator spectre
    Outputs: VT(""); vin_trans; "/voutp"; "/voutn"; (VT("/sum1p") - VT("/sum1n")); noise; "/vinp1"; /vinn; "/vinp"; /vinp; /voutp1; /voutn1; "/voutp_vams"; "/voutn_vams"; "/voutp_mos_ac"; gain_1; gain_dB_1; phase_1; GBW_1; PM_1; BW_1; vout_trans_1
Global variables:
  t_trans = 5m
  vcm = 0
  vpk = 0.1
  fs = 62.5k
  f0 = 1k,15k,62.5k
  fB = fs/(2*256)
  Av_dB = 70
  Av = 10**(Av_dB/20)
  BW = fs
  SR = 2*3.1416*Av*BW*1.8
  Cf = 30p
  b1 = 2
  Roff = 500M
  Ron = 10
  tf = 20n
  tr = 20n
