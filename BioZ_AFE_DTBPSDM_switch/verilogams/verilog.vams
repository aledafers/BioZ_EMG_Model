//Verilog-AMS HDL for "IL2239_SAR_ADC", "relay" "verilogams"

`include "constants.vams"
`include "disciplines.vams"

module BioZ_AFE_DTBPSDM_switch ( in, out, gate );

	parameter real VTHn=0.9;
	parameter real Ron=1;
	parameter real Roff=1e9;
	parameter real tdelay = 0;
	parameter real trise = 2e-9;
	parameter real tfall = 2e-9;

	real Irelay, reff;

	input gate;
	inout in, out;
	electrical in, out, gate;

	analog begin
		if (V(gate)>VTHn) begin
			reff = Ron;
			//Irelay = V(in,out)/Ron;
		end else	begin
			reff = Roff;
			//Irelay = V(in,out)/Roff;
		end
	I(in,out) <+ V(in,out)/transition( reff, tdelay, trise, tfall );
	//I(in,out) <+ transition( Irelay, delay, trise, tfall );	//To avoid abrupt changes, to add transition slew
	//I(in,out) <+ Irelay;
	end

endmodule
