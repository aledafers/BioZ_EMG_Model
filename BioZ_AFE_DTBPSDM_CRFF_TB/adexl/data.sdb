ADE simulation setup
Run mode: Single Run, Sweeps and Corners
Tests:
  BioZ_EMG_Model:BioZ_AFE_DTBPSDM_CRFF_TB:1: BioZ_EMG_Model/BioZ_AFE_DTBPSDM_CRFF_TB/config, simulator ams
    Outputs: VT(""); SDM_in; int1; int2; int3; int4; SDM_out; vdac; /sum1p; /sum1n; sum1; /compp; /compn; (VT("/sum1p") - VT("/sum1n")); comp
Global variables:
  t_trans = 263m
  Voh = 1.8
  vcm = 900m
  vpk = 0.8
  fs = 62.5k
  f0 = fs/4
  fB = fs/(2*256)
  g_coeff = 1
  a1 = 1.0715
  a2 = 0.6558
  a3 = 0.0755
  a4 = 2.6173
  b1 = 0.3817
  c1 = 0.3817
  c2 = 1.6339
  c3 = 0.0616
  c4 = 1.0748
  g1 = 1.2284*g_coeff
  g2 = 1.8543*g_coeff
  Cf = 300p
  Av_dB = 60
  Av = 10**(Av_dB/20)
  BW = 6*fs
  SR = 2*pi*Av*BW*Voh
  tr = 20n
  tf = 20n
  Roff = 500M
  Ron = 140
  Rdc = 300
  Rac = 100
  pi = 3.1416
  Voffp_comp = 0
  Voffn_comp = 0
  tdel_comp = 0
