ADE simulation setup
Run mode: Single Run, Sweeps and Corners
Tests:
  BioZ_EMG_Model:BioZ_TB:1: BioZ_EMG_Model/BioZ_TB/config, simulator ams
    Outputs: "/"; SigGen_Ioutp; SigGen_Ioutn; SigGen_IP; SigGen_IN; SigGen_QP; SigGen_QN; SigGen_Fsel; AFE_I_ADC_Dout; AFE_Q_ADC_Dout; BioZ_OUT_I_DAC; BioZ_OUT_Q_DAC; AFE_I_Vout; AFE_Q_Vout
Global variables:
  t_meas = 49.5m
