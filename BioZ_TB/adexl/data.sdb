ADE simulation setup
Run mode: Single Run, Sweeps and Corners
Tests:
  BioZ_EMG_Model:BioZ_TB:1: BioZ_EMG_Model/BioZ_TB/config, simulator ams
    Outputs: "/"; SigGen_Ioutp; SigGen_Ioutn; SigGen_IP; SigGen_IN; SigGen_QP; SigGen_QN; SigGen_Fsel; AFE_BioZ_OUT_I_DAC; AFE_BioZ_OUT_Q_DAC; AFE_I_Vout; AFE_Q_Vout; AFE_Vdiff_bioz; SigGen_Ioutdiff; AFE_TIA_I; AFE_TIA_Q; AFE_MIX_I_IF; AFE_MIX_Q_IF; AFE_TCA_I; "/I5/IF_P"; "/I5/IF_N"; AFE_TCA_Q; "/I5/I6/IoutP_1"; "/I5/I6/IoutN_1"; "/I5/I(/IoutP_2"; "/I5/I8/IoutN_2"; "/I5/I8/IoutP_2"; AFE_MIX_I_BB; AFE_MIX_Q_BB
Global variables:
  t_meas = 9m
