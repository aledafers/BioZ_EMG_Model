ADE simulation setup
Run mode: Single Run, Sweeps and Corners
Tests:
  BioZ_EMG_Model:BioZ_AFE_DTBPSDM_CRFF_N-path_v6_TB:1: BioZ_EMG_Model/BioZ_AFE_DTBPSDM_CRFF_N-path_v6_SP_TB/config, simulator ams
    Outputs: VT(""); SDM_in; res1; res2; SDM_out; vdac; /sum1p; /sum1n; sum1; /compp; /compn; (VT("/sum1p") - VT("/sum1n")); comp; /a1; "/a2"; "/b1"; /b2; /a2; /b1; /c1; /c2; res3
Global variables:
  t_trans = 1.05
  pi = 3.1416
  Voh = 1.8
  vcm = 0.9
  dBfs = -3
  vpk = 0.9*10**(dBfs/20)
  fs = 62.5k
  f0 = fs/4
  fB = fs/(2*256)
  a1 = 1.0669
  a2 = 0.9777
  a3 = 1.3350
  b1 = 0.4891
  c1 = 0.4891
  c2 = 0.2660
  c3 = 0.0794
  Cf = 5p,10p,15p,20p,25p
  Ch = Cf/10
  cap_mismatch = 0
  tr = 20n
  tf = 20n
  Ron = 10
  Roff = 500M
  Voffp_comp = 0
  Voffn_comp = 0
  tdelay_comp = 0
Single Run, Sweeps and Corners options: submitpointsenabled=0
