ADE simulation setup
Run mode: Single Run, Sweeps and Corners
Tests:
  BioZ_EMG_Model:BioZ_AFE_DTBPSDM_CRFB_TB:1: BioZ_EMG_Model/BioZ_AFE_DTBPSDM_CRFB_TB/config, simulator ams
    Outputs: VT(""); SDM_in; int1; int2; int3; int4; SDM_out; vdac; /sum1p; /sum1n; sum1; /compp; /compn; (VT("/sum1p") - VT("/sum1n")); comp
Global variables:
  t_trans = 263m
  Voh = 1.8
  vcm = 900m
  vpk = 0.7
  fs = 62.5k
  f0 = fs/4
  fB = fs/(2*256)
  g_leak = 1
  a1 = 0.1541*g_leak
  a2 = 0.0056*g_leak
  a3 = 0.1335*g_leak
  a4 = 0.1517*g_leak
  b1 = 0.1585*g_leak
  c1 = 1.2737*g_leak
  c2 = 0.1670*g_leak
  c3 = 1.1366*g_leak
  c4 = 2.6953*g_leak
  g1 = 1.5757*g_leak
  g2 = 1.7533*g_leak
  Cf = 300p
  Av_dB = 60
  Av = 10**(Av_dB/20)
  BW = 6*fs
  GBW = Av*BW
  SR = 2*pi*Av*BW*Voh
  tr = 20n
  tf = 20n
  Roff = 500M
  Ron = 140
  Rac = 100
  Rdc = 300
  pi = 3.1416
  ip3 = 1
  Voffp_comp = 0
  Voffn_comp = 0
  tdelay_comp = 0
