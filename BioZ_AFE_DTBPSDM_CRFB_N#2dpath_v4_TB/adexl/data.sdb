ADE simulation setup
Run mode: Single Run, Sweeps and Corners
Tests:
  BioZ_EMG_Model:BioZ_AFE_DTBPSDM_CRFB_N-path_v4_TB:1: BioZ_EMG_Model/BioZ_AFE_DTBPSDM_CRFB_N-path_v4_TB/config, simulator ams
    Outputs: VT(""); SDM_in; res1; res2; (VT("/sum1p") - VT("/sum1n")); SDM_out; /phi1_d; /phi2_d; /SDM_out; SDM_out_1; SDM_out_2
Global variables:
  t_trans = 5m
  pi = 3.1416
  Voh = 1.8
  vcm = 900m
  vpk = 0.8
  fs = 62.5k
  f0 = fs/4
  fB = fs/(2*256)
  a1 = 0.1976
  a2 = 0.1540
  b1 = 0.1976
  c1 = 0.1987
  c2 = 2.6731
  Cf = 200p
  Av1_dB = 100
  Av2_dB = 100
  Av1 = 10**(Av1_dB/20)
  Av2 = 10**(Av2_dB/20)
  BW1 = fs
  BW2 = fs
  GBW1 = Av1*BW1
  GBW2 = Av2*BW2
  SR1 = 2*pi*GBW1*Voh
  SR2 = 2*pi*GBW2*Voh
  tr = 20n
  tf = 20n
  Rdc = 300
  Rac = 100
  Ron = 1
  Roff = 1e9
  Voffp_comp = 0
  Voffn_comp = 0
  tdelay_comp = 0
  BW = fs
