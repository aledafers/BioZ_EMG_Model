ADE simulation setup
Run mode: Single Run, Sweeps and Corners
Tests:
  BioZ_EMG_Model:BioZ_EMG_Combined_TB:1: BioZ_EMG_Model/BioZ_EMG_Combined_TB/config, simulator ams
    Outputs: SigGen_IoutP; SigGen_IoutN; SigGen_IP; SigGen_IN; SigGen_QP; SigGen_QN; SigGen_Fsel; AFE_I_ADC_Dout; AFE_Q_ADC_Dout; AFE_I_Vout; AFE_Q_Vout; SigGen_IoutP1; SigGen_IoutN1; SigGen_IP1; SigGen_IN1; SigGen_QP1; SigGen_QN1; SigGen_Fsel1; AFE_I_ADC_Dout1; AFE_Q_ADC_Dout1; AFE_I_Vout1; AFE_Q_Vout1
Global variables:
  t_meas = 4m
  EMG_amp = 250u
  EMG_freq = 500
