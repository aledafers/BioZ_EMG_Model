ADE simulation setup
Run mode: Single Run, Sweeps and Corners
Tests:
  BioZ_EMG_Model:BioZ_EMG_Combined_TB:1: BioZ_EMG_Model/BioZ_EMG_Combined_TB/config, simulator ams
Global variables:
  t_meas = 49.5m
