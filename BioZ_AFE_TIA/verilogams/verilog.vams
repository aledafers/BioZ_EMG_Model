//Verilog-AMS HDL for "BioZ_EMG_Model", "BioZ_AFE_TIA" "verilogams"

`include "constants.vams"
`include "disciplines.vams"

module BioZ_AFE_TIA ( voutn, voutp, Gain, Iinn, Iinp, bias_in, bias_CMFB, vdda, vddd, vssa, vssd, vsub );

inout voutp;
inout voutn;
input vsub;
inout Iinn;
input vdda;
input vddd;
input bias_in;
input bias_CMFB;
inout Iinp;
input vssa;
input vssd;
input Gain;

logic Gain;
electrical voutn, voutp, Iinn, Iinp, vssa;

parameter real fc = 40k from (0:1M];
parameter real vcm = 0.9 ;
parameter real Av = 10000; //DC voltage Gain
parameter real ip3 = -99.6;// 3rd order intercept point in dBm

parameter real RS = 1M; //Source Resistance

real RF = 10e6; //Transimpedance
real vdif;
real c, ip, Vin, Voutmax, Vinmax, Vout;

  //Digital part
always @(Gain) begin
	if (Gain == 0) begin // Low Gain, RF = 3M
 		RF = 3.33333e6;
	end else begin // High Gain RF = 10M
		RF = 10e6;
	end
end

//Analog part
analog begin

	@(initial_step) begin
		//Nonlinearity Model
		c = Av*(4/3)/(pow(10,ip3/10)*2*RS*0.001);

		// Compute the critical point
		Vinmax = sqrt(Av/(3*c));
		Voutmax = (2*Av/3)*Vinmax;
	end

	// Assign the input voltage to the variable, Vin
	Vin = V(Iinp,Iinn);

	// Apply the third order nonlinearity. Clamp the output for extreme inputs
	if (abs(Vin) < Vinmax)
		vdif = (Av - c*Vin*Vin)*Vin;
	else if (Vin > 0)
		vdif = Voutmax;
	else
		vdif = -Voutmax;

	//vdif = Av*Vin;

	//Set the common mode
	V(voutp,vssa) <+ vdif/2 + vcm;
	V(voutn,vssa) <+ -vdif/2 + vcm;

    //Transimpedance amplifier
	//V(Iinp,voutn) <+ laplace_np(-I(Iinp,voutn)*RF/2,{1},{-`M_TWO_PI*fc,0});
	//V(Iinn,voutp) <+ laplace_np(-I(Iinn,voutp)*RF/2,{1},{-`M_TWO_PI*fc,0});

    I(Iinp,voutn) <+ laplace_zd(-V(Iinp,voutn)/(RF/2),{-`M_TWO_PI*fc,0},{1});
    I(Iinn,voutp) <+ laplace_zd(-V(Iinn,voutp)/(RF/2),{-`M_TWO_PI*fc,0},{1});

	//Noise Model
	I(Iinp,Iinn) <+ noise_table("/home/fernande/cadence/workingdir/BioZ_EMG_Model/BioZ_TIA_noise_table", "TIA_noise");

end

endmodule
