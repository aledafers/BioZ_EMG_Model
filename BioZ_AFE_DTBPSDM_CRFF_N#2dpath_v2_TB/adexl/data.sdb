ADE simulation setup
Run mode: Single Run, Sweeps and Corners
Tests:
  BioZ_EMG_Model:BioZ_AFE_DTBPSDM_CRFF_N-path_v2_TB:1: BioZ_EMG_Model/BioZ_AFE_DTBPSDM_CRFF_N-path_v2_TB/config, simulator ams
    Outputs: VT(""); SDM_in; res1; res2; SDM_out; vdac; /sum1p; /sum1n; sum1; /compp; /compn; (VT("/sum1p") - VT("/sum1n")); comp
Global variables:
  t_trans = 263m
  pi = 3.1416
  Voh = 1.8
  vcm = 900m
  vpk = 0.8
  fs = 62.5k
  f0 = fs/4
  fB = fs/(2*256)
  a1 = 0.6192
  a2 = 3.3161
  b1 = 0.6606
  c1 = 0.6606
  c2 = 0.048
  Cf = 20p
  Av_dB = 80
  Av = 10**(Av_dB/20)
  BW = fs
  GBW = Av*BW
  SR = 2*pi*GBW*Voh
  tr = 20n
  tf = 20n
  Rdc = 300
  Rac = 100
  Ron = 1
  Roff = 1e9
  Voffp_comp = 0
  Voffn_comp = 0
  tdelay_comp = 0
