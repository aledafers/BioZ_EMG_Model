//Verilog-AMS HDL for "BioZ_EMG_Model", "BioZ_EMG_SwitchArray16" "verilogams"

`include "constants.vams"
`include "disciplines.vams"

module BioZ_EMG_SwitchArray16 ( EMG_Ch1, EMG_Ch2, EMG_Ch3, EMG_Ch4, EMG_Ch5, EMG_Ch6, EMG_Ch7, EMG_Ch8, EMG_Ch9,
							EMG_Ch10, EMG_Ch11, EMG_Ch12, EMG_Ch13, EMG_Ch14, EMG_Ch15, EMG_Ch16, BI_Ip, BI_In, BI_Vp, BI_Vn,
							E00, E01, E02, E03, E10, E11, E12, E13, E20, E21, E22, E23, E30, E31, E32, E33,
							Dir, Row, Col, SenseMode, Vdda, Vssa, Vsub, Vddd, Vssd);

// characteristics of switches
parameter real ron = 1 from [1:inf); 		// on resistance
parameter real roff = 1G from [1:inf); 	// off resistance
parameter real rgnd = 1G from [1:inf); 		// path to gnd resistance
parameter real tr = 200n; // rise time
parameter real tf = 200n; // fall time
parameter real td = 0; // delay

//IO ports declaration
inout 	EMG_Ch1, EMG_Ch2, EMG_Ch3, EMG_Ch4, EMG_Ch5, EMG_Ch6, EMG_Ch7, EMG_Ch8, EMG_Ch9,
		EMG_Ch10, EMG_Ch11, EMG_Ch12, EMG_Ch13, EMG_Ch14, EMG_Ch15, EMG_Ch16,
		BI_Ip, BI_In, BI_Vp, BI_Vn, E00, E01, E02, E03, E10, E11, E12, E13, E20, E21, E22, E23, E30, E31, E32, E33;
input 	Dir;
input [1:0] Row, Col;
input [2:0] SenseMode;
inout Vdda, Vssa, Vsub, Vddd, Vssd;

// Type of ports
electrical 	EMG_Ch1, EMG_Ch2, EMG_Ch3, EMG_Ch4, EMG_Ch5, EMG_Ch6, EMG_Ch7, EMG_Ch8, EMG_Ch9,
			EMG_Ch10, EMG_Ch11, EMG_Ch12, EMG_Ch13, EMG_Ch14, EMG_Ch15, EMG_Ch16,
			BI_Ip, BI_In, BI_Vp, BI_Vn, E00, E01, E02, E03, E10, E11, E12,
			E13, E20, E21, E22, E23, E30, E31, E32, E33, Vdda, Vssa, Vsub, Vddd, Vssd;

// Effective only when BI mode is chosen
logic Dir; 		// Direction of current injection and voltage sensing (1: parallel to fiber; 0: perpendicular fiber)
logic Dis; 		// Distance of BI measurement (0: long; 1: short)
logic [1:0] Row; 	// Row selection
logic [1:0] Col; 	// Column selection
logic [2:0] SenseMode; // Impedance to Measure (0: BioZ; 1: Electrode1; 2: Electrode2; 3: Electrode3; 4: Electrode4;)

analog begin
	I(E00, EMG_Ch1) <+ V(E00, EMG_Ch1)/ron;
	I(E01, EMG_Ch2) <+ V(E01, EMG_Ch2)/ron;
	I(E02, EMG_Ch3) <+ V(E02, EMG_Ch3)/ron;
	I(E03, EMG_Ch4) <+ V(E03, EMG_Ch4)/ron;
	I(E10, EMG_Ch5) <+ V(E10, EMG_Ch5)/ron;
	I(E11, EMG_Ch6) <+ V(E11, EMG_Ch6)/ron;
	I(E12, EMG_Ch7) <+ V(E12, EMG_Ch7)/ron;
	I(E13, EMG_Ch8) <+ V(E13, EMG_Ch8)/ron;
	I(E20, EMG_Ch9) <+ V(E20, EMG_Ch9)/ron;
	I(E21, EMG_Ch10) <+ V(E21, EMG_Ch10)/ron;
	I(E22, EMG_Ch11) <+ V(E22, EMG_Ch11)/ron;
	I(E23, EMG_Ch12) <+ V(E23, EMG_Ch12)/ron;
	I(E30, EMG_Ch13) <+ V(E30, EMG_Ch13)/ron;
	I(E31, EMG_Ch14) <+ V(E31, EMG_Ch14)/ron;
	I(E32, EMG_Ch15) <+ V(E32, EMG_Ch15)/ron;
	I(E33, EMG_Ch16) <+ V(E33, EMG_Ch16)/ron;

	I(BI_Ip,Vssa) <+ V(BI_Ip,Vssa)/rgnd;
	I(BI_Vp,Vssa) <+ V(BI_Vp,Vssa)/rgnd;
	I(BI_Vn,Vssa) <+ V(BI_Vn,Vssa)/rgnd;
	I(BI_In,Vssa) <+ V(BI_In,Vssa)/rgnd;

	if (Dir == 1'b1) begin
		case(Row)
			2'b00: begin
				case(SenseMode)
					3'b000: begin
						I(E00,BI_Ip) <+ V(E00,BI_Ip)/ron;
						I(E01,BI_Vp) <+ V(E01,BI_Vp)/ron;
						I(E02,BI_Vn) <+ V(E02,BI_Vn)/ron;
						I(E03,BI_In) <+ V(E03,BI_In)/ron;
					end
					3'b001: begin
						I(E00,BI_Ip) <+ V(E00,BI_Ip)/ron;
						I(E02,BI_Vp) <+ V(E02,BI_Vp)/ron;
						I(E00,BI_Vn) <+ V(E00,BI_Vn)/ron;
						I(E01,BI_In) <+ V(E01,BI_In)/ron;
						I(E03,BI_In) <+ V(E03,BI_In)*roff;
					end
					3'b010: begin
						I(E01,BI_Ip) <+ V(E01,BI_Ip)/ron;
						I(E02,BI_Vp) <+ V(E02,BI_Vp)/ron;
						I(E01,BI_Vn) <+ V(E01,BI_Vn)/ron;
						I(E00,BI_In) <+ V(E00,BI_In)/ron;
						I(E03,BI_In) <+ V(E03,BI_In)/roff;
					end
					3'b011: begin
						I(E02,BI_Ip) <+ V(E02,BI_Ip)/ron;
						I(E00,BI_Vp) <+ V(E00,BI_Vp)/ron;
						I(E02,BI_Vn) <+ V(E02,BI_Vn)/ron;
						I(E01,BI_In) <+ V(E01,BI_In)/ron;
						I(E01,BI_In) <+ V(E01,BI_In)/roff;
					end
					3'b100: begin
						I(E03,BI_Ip) <+ V(E03,BI_Ip)/ron;
						I(E00,BI_Vp) <+ V(E00,BI_Vp)/ron;
						I(E03,BI_Vn) <+ V(E03,BI_Vn)/ron;
						I(E02,BI_In) <+ V(E02,BI_In)/ron;
						I(E01,BI_In) <+ V(E01,BI_In)/roff;
					end
				endcase
						I(E10,BI_Ip) <+ V(E10,BI_Ip)/roff;
						I(E11,BI_Vp) <+ V(E11,BI_Vp)/roff;
						I(E12,BI_Vn) <+ V(E12,BI_Vn)/roff;
						I(E13,BI_In) <+ V(E13,BI_In)/roff;
						I(E20,BI_Ip) <+ V(E20,BI_Ip)/roff;
						I(E21,BI_Vp) <+ V(E21,BI_Vp)/roff;
						I(E22,BI_Vn) <+ V(E22,BI_Vn)/roff;
						I(E23,BI_In) <+ V(E23,BI_In)/roff;
						I(E30,BI_Ip) <+ V(E30,BI_Ip)/roff;
						I(E31,BI_Vp) <+ V(E31,BI_Vp)/roff;
						I(E32,BI_Vn) <+ V(E32,BI_Vn)/roff;
						I(E33,BI_In) <+ V(E33,BI_In)/roff;
			end
			2'b01: begin
				case(SenseMode)
					3'b000: begin
						I(E10,BI_Ip) <+ V(E10,BI_Ip)/ron;
						I(E11,BI_Vp) <+ V(E11,BI_Vp)/ron;
						I(E12,BI_Vn) <+ V(E12,BI_Vn)/ron;
						I(E13,BI_In) <+ V(E13,BI_In)/ron;
					end
					3'b001: begin
						I(E10,BI_Ip) <+ V(E10,BI_Ip)/ron;
						I(E12,BI_Vp) <+ V(E12,BI_Vp)/ron;
						I(E10,BI_Vn) <+ V(E10,BI_Vn)/ron;
						I(E11,BI_In) <+ V(E11,BI_In)/ron;
						I(E13,BI_In) <+ V(E13,BI_In)*roff;
					end
					3'b010: begin
						I(E11,BI_Ip) <+ V(E11,BI_Ip)/ron;
						I(E12,BI_Vp) <+ V(E12,BI_Vp)/ron;
						I(E11,BI_Vn) <+ V(E11,BI_Vn)/ron;
						I(E10,BI_In) <+ V(E10,BI_In)/ron;
						I(E13,BI_In) <+ V(E13,BI_In)/roff;
					end
					3'b011: begin
						I(E12,BI_Ip) <+ V(E12,BI_Ip)/ron;
						I(E10,BI_Vp) <+ V(E10,BI_Vp)/ron;
						I(E12,BI_Vn) <+ V(E12,BI_Vn)/ron;
						I(E11,BI_In) <+ V(E11,BI_In)/ron;
						I(E11,BI_In) <+ V(E11,BI_In)/roff;
					end
					3'b100: begin
						I(E13,BI_Ip) <+ V(E13,BI_Ip)/ron;
						I(E10,BI_Vp) <+ V(E10,BI_Vp)/ron;
						I(E13,BI_Vn) <+ V(E13,BI_Vn)/ron;
						I(E12,BI_In) <+ V(E12,BI_In)/ron;
						I(E11,BI_In) <+ V(E11,BI_In)/roff;
					end
				endcase
						I(E00,BI_Ip) <+ V(E00,BI_Ip)/roff;
						I(E01,BI_Vp) <+ V(E01,BI_Vp)/roff;
						I(E02,BI_Vn) <+ V(E02,BI_Vn)/roff;
						I(E03,BI_In) <+ V(E03,BI_In)/roff;
						I(E20,BI_Ip) <+ V(E20,BI_Ip)/roff;
						I(E21,BI_Vp) <+ V(E21,BI_Vp)/roff;
						I(E22,BI_Vn) <+ V(E22,BI_Vn)/roff;
						I(E23,BI_In) <+ V(E23,BI_In)/roff;
						I(E30,BI_Ip) <+ V(E30,BI_Ip)/roff;
						I(E31,BI_Vp) <+ V(E31,BI_Vp)/roff;
						I(E32,BI_Vn) <+ V(E32,BI_Vn)/roff;
						I(E33,BI_In) <+ V(E33,BI_In)/roff;
			end
			2'b10: begin
				case(SenseMode)
					3'b000: begin
						I(E20,BI_Ip) <+ V(E20,BI_Ip)/ron;
						I(E21,BI_Vp) <+ V(E21,BI_Vp)/ron;
						I(E22,BI_Vn) <+ V(E22,BI_Vn)/ron;
						I(E23,BI_In) <+ V(E23,BI_In)/ron;
					end
					3'b001: begin
						I(E20,BI_Ip) <+ V(E20,BI_Ip)/ron;
						I(E22,BI_Vp) <+ V(E22,BI_Vp)/ron;
						I(E20,BI_Vn) <+ V(E20,BI_Vn)/ron;
						I(E21,BI_In) <+ V(E21,BI_In)/ron;
						I(E23,BI_In) <+ V(E23,BI_In)*roff;
					end
					3'b010: begin
						I(E21,BI_Ip) <+ V(E21,BI_Ip)/ron;
						I(E22,BI_Vp) <+ V(E22,BI_Vp)/ron;
						I(E21,BI_Vn) <+ V(E21,BI_Vn)/ron;
						I(E20,BI_In) <+ V(E20,BI_In)/ron;
						I(E23,BI_In) <+ V(E23,BI_In)/roff;
					end
					3'b011: begin
						I(E22,BI_Ip) <+ V(E22,BI_Ip)/ron;
						I(E20,BI_Vp) <+ V(E20,BI_Vp)/ron;
						I(E22,BI_Vn) <+ V(E22,BI_Vn)/ron;
						I(E21,BI_In) <+ V(E21,BI_In)/ron;
						I(E21,BI_In) <+ V(E21,BI_In)/roff;
					end
					3'b100: begin
						I(E23,BI_Ip) <+ V(E23,BI_Ip)/ron;
						I(E20,BI_Vp) <+ V(E20,BI_Vp)/ron;
						I(E23,BI_Vn) <+ V(E23,BI_Vn)/ron;
						I(E22,BI_In) <+ V(E22,BI_In)/ron;
						I(E21,BI_In) <+ V(E21,BI_In)/roff;
					end
				endcase
						I(E10,BI_Ip) <+ V(E10,BI_Ip)/roff;
						I(E11,BI_Vp) <+ V(E11,BI_Vp)/roff;
						I(E12,BI_Vn) <+ V(E12,BI_Vn)/roff;
						I(E13,BI_In) <+ V(E13,BI_In)/roff;
						I(E00,BI_Ip) <+ V(E00,BI_Ip)/roff;
						I(E01,BI_Vp) <+ V(E01,BI_Vp)/roff;
						I(E02,BI_Vn) <+ V(E02,BI_Vn)/roff;
						I(E03,BI_In) <+ V(E03,BI_In)/roff;
						I(E30,BI_Ip) <+ V(E30,BI_Ip)/roff;
						I(E31,BI_Vp) <+ V(E31,BI_Vp)/roff;
						I(E32,BI_Vn) <+ V(E32,BI_Vn)/roff;
						I(E33,BI_In) <+ V(E33,BI_In)/roff;
			end
			2'b11: begin
				case(SenseMode)
					3'b000: begin
						I(E30,BI_Ip) <+ V(E30,BI_Ip)/ron;
						I(E31,BI_Vp) <+ V(E31,BI_Vp)/ron;
						I(E32,BI_Vn) <+ V(E32,BI_Vn)/ron;
						I(E33,BI_In) <+ V(E33,BI_In)/ron;
					end
					3'b001: begin
						I(E30,BI_Ip) <+ V(E30,BI_Ip)/ron;
						I(E32,BI_Vp) <+ V(E32,BI_Vp)/ron;
						I(E30,BI_Vn) <+ V(E30,BI_Vn)/ron;
						I(E31,BI_In) <+ V(E31,BI_In)/ron;
						I(E33,BI_In) <+ V(E33,BI_In)*roff;
					end
					3'b010: begin
						I(E31,BI_Ip) <+ V(E31,BI_Ip)/ron;
						I(E32,BI_Vp) <+ V(E32,BI_Vp)/ron;
						I(E31,BI_Vn) <+ V(E31,BI_Vn)/ron;
						I(E30,BI_In) <+ V(E30,BI_In)/ron;
						I(E33,BI_In) <+ V(E33,BI_In)/roff;
					end
					3'b011: begin
						I(E32,BI_Ip) <+ V(E32,BI_Ip)/ron;
						I(E30,BI_Vp) <+ V(E30,BI_Vp)/ron;
						I(E32,BI_Vn) <+ V(E32,BI_Vn)/ron;
						I(E31,BI_In) <+ V(E31,BI_In)/ron;
						I(E31,BI_In) <+ V(E31,BI_In)/roff;
					end
					3'b100: begin
						I(E33,BI_Ip) <+ V(E33,BI_Ip)/ron;
						I(E30,BI_Vp) <+ V(E30,BI_Vp)/ron;
						I(E33,BI_Vn) <+ V(E33,BI_Vn)/ron;
						I(E32,BI_In) <+ V(E32,BI_In)/ron;
						I(E31,BI_In) <+ V(E31,BI_In)/roff;
					end
				endcase
						I(E10,BI_Ip) <+ V(E10,BI_Ip)/roff;
						I(E11,BI_Vp) <+ V(E11,BI_Vp)/roff;
						I(E12,BI_Vn) <+ V(E12,BI_Vn)/roff;
						I(E13,BI_In) <+ V(E13,BI_In)/roff;
						I(E20,BI_Ip) <+ V(E20,BI_Ip)/roff;
						I(E21,BI_Vp) <+ V(E21,BI_Vp)/roff;
						I(E22,BI_Vn) <+ V(E22,BI_Vn)/roff;
						I(E23,BI_In) <+ V(E23,BI_In)/roff;
						I(E00,BI_Ip) <+ V(E00,BI_Ip)/roff;
						I(E01,BI_Vp) <+ V(E01,BI_Vp)/roff;
						I(E02,BI_Vn) <+ V(E02,BI_Vn)/roff;
						I(E03,BI_In) <+ V(E03,BI_In)/roff;
			end
		endcase
	end
	else if (Dir == 1'b0) begin
		case(Row)
			2'b00: begin
				case(SenseMode)
					3'b000: begin
						I(E00,BI_Ip) <+ V(E00,BI_Ip)/ron;
						I(E10,BI_Vp) <+ V(E10,BI_Vp)/ron;
						I(E20,BI_Vn) <+ V(E20,BI_Vn)/ron;
						I(E30,BI_In) <+ V(E30,BI_In)/ron;
					end
					3'b001: begin
						I(E00,BI_Ip) <+ V(E00,BI_Ip)/ron;
						I(E20,BI_Vp) <+ V(E20,BI_Vp)/ron;
						I(E00,BI_Vn) <+ V(E00,BI_Vn)/ron;
						I(E10,BI_In) <+ V(E10,BI_In)/ron;
						I(E30,BI_In) <+ V(E30,BI_In)*roff;
					end
					3'b010: begin
						I(E10,BI_Ip) <+ V(E10,BI_Ip)/ron;
						I(E20,BI_Vp) <+ V(E20,BI_Vp)/ron;
						I(E10,BI_Vn) <+ V(E10,BI_Vn)/ron;
						I(E00,BI_In) <+ V(E00,BI_In)/ron;
						I(E30,BI_In) <+ V(E30,BI_In)/roff;
					end
					3'b011: begin
						I(E20,BI_Ip) <+ V(E20,BI_Ip)/ron;
						I(E00,BI_Vp) <+ V(E00,BI_Vp)/ron;
						I(E20,BI_Vn) <+ V(E20,BI_Vn)/ron;
						I(E10,BI_In) <+ V(E10,BI_In)/ron;
						I(E10,BI_In) <+ V(E10,BI_In)/roff;
					end
					3'b100: begin
						I(E30,BI_Ip) <+ V(E30,BI_Ip)/ron;
						I(E00,BI_Vp) <+ V(E00,BI_Vp)/ron;
						I(E30,BI_Vn) <+ V(E30,BI_Vn)/ron;
						I(E20,BI_In) <+ V(E20,BI_In)/ron;
						I(E10,BI_In) <+ V(E10,BI_In)/roff;
					end
				endcase
						I(E01,BI_Ip) <+ V(E01,BI_Ip)/roff;
						I(E11,BI_Vp) <+ V(E11,BI_Vp)/roff;
						I(E21,BI_Vn) <+ V(E21,BI_Vn)/roff;
						I(E31,BI_In) <+ V(E31,BI_In)/roff;
						I(E02,BI_Ip) <+ V(E02,BI_Ip)/roff;
						I(E12,BI_Vp) <+ V(E12,BI_Vp)/roff;
						I(E22,BI_Vn) <+ V(E22,BI_Vn)/roff;
						I(E32,BI_In) <+ V(E32,BI_In)/roff;
						I(E03,BI_Ip) <+ V(E03,BI_Ip)/roff;
						I(E13,BI_Vp) <+ V(E13,BI_Vp)/roff;
						I(E23,BI_Vn) <+ V(E23,BI_Vn)/roff;
						I(E33,BI_In) <+ V(E33,BI_In)/roff;
			end
			2'b01: begin
				case(SenseMode)
					3'b000: begin
						I(E01,BI_Ip) <+ V(E01,BI_Ip)/ron;
						I(E11,BI_Vp) <+ V(E11,BI_Vp)/ron;
						I(E21,BI_Vn) <+ V(E21,BI_Vn)/ron;
						I(E31,BI_In) <+ V(E31,BI_In)/ron;
					end
					3'b001: begin
						I(E01,BI_Ip) <+ V(E01,BI_Ip)/ron;
						I(E21,BI_Vp) <+ V(E21,BI_Vp)/ron;
						I(E01,BI_Vn) <+ V(E01,BI_Vn)/ron;
						I(E11,BI_In) <+ V(E11,BI_In)/ron;
						I(E31,BI_In) <+ V(E31,BI_In)*roff;
					end
					3'b010: begin
						I(E11,BI_Ip) <+ V(E11,BI_Ip)/ron;
						I(E21,BI_Vp) <+ V(E21,BI_Vp)/ron;
						I(E11,BI_Vn) <+ V(E11,BI_Vn)/ron;
						I(E01,BI_In) <+ V(E01,BI_In)/ron;
						I(E31,BI_In) <+ V(E31,BI_In)/roff;
					end
					3'b011: begin
						I(E21,BI_Ip) <+ V(E21,BI_Ip)/ron;
						I(E01,BI_Vp) <+ V(E01,BI_Vp)/ron;
						I(E21,BI_Vn) <+ V(E21,BI_Vn)/ron;
						I(E11,BI_In) <+ V(E11,BI_In)/ron;
						I(E11,BI_In) <+ V(E11,BI_In)/roff;
					end
					3'b100: begin
						I(E31,BI_Ip) <+ V(E31,BI_Ip)/ron;
						I(E01,BI_Vp) <+ V(E01,BI_Vp)/ron;
						I(E31,BI_Vn) <+ V(E31,BI_Vn)/ron;
						I(E21,BI_In) <+ V(E21,BI_In)/ron;
						I(E11,BI_In) <+ V(E11,BI_In)/roff;
					end
				endcase
						I(E00,BI_Ip) <+ V(E00,BI_Ip)/roff;
						I(E10,BI_Vp) <+ V(E10,BI_Vp)/roff;
						I(E20,BI_Vn) <+ V(E20,BI_Vn)/roff;
						I(E30,BI_In) <+ V(E30,BI_In)/roff;
						I(E02,BI_Ip) <+ V(E02,BI_Ip)/roff;
						I(E12,BI_Vp) <+ V(E12,BI_Vp)/roff;
						I(E22,BI_Vn) <+ V(E22,BI_Vn)/roff;
						I(E32,BI_In) <+ V(E32,BI_In)/roff;
						I(E03,BI_Ip) <+ V(E03,BI_Ip)/roff;
						I(E13,BI_Vp) <+ V(E13,BI_Vp)/roff;
						I(E23,BI_Vn) <+ V(E23,BI_Vn)/roff;
						I(E33,BI_In) <+ V(E33,BI_In)/roff;
			end
			2'b10: begin
				case(SenseMode)
					3'b000: begin
						I(E02,BI_Ip) <+ V(E02,BI_Ip)/ron;
						I(E12,BI_Vp) <+ V(E12,BI_Vp)/ron;
						I(E22,BI_Vn) <+ V(E22,BI_Vn)/ron;
						I(E32,BI_In) <+ V(E32,BI_In)/ron;
					end
					3'b001: begin
						I(E02,BI_Ip) <+ V(E02,BI_Ip)/ron;
						I(E22,BI_Vp) <+ V(E22,BI_Vp)/ron;
						I(E02,BI_Vn) <+ V(E02,BI_Vn)/ron;
						I(E12,BI_In) <+ V(E12,BI_In)/ron;
						I(E32,BI_In) <+ V(E32,BI_In)*roff;
					end
					3'b010: begin
						I(E12,BI_Ip) <+ V(E12,BI_Ip)/ron;
						I(E22,BI_Vp) <+ V(E22,BI_Vp)/ron;
						I(E12,BI_Vn) <+ V(E12,BI_Vn)/ron;
						I(E02,BI_In) <+ V(E02,BI_In)/ron;
						I(E32,BI_In) <+ V(E32,BI_In)/roff;
					end
					3'b011: begin
						I(E22,BI_Ip) <+ V(E22,BI_Ip)/ron;
						I(E02,BI_Vp) <+ V(E02,BI_Vp)/ron;
						I(E22,BI_Vn) <+ V(E22,BI_Vn)/ron;
						I(E12,BI_In) <+ V(E12,BI_In)/ron;
						I(E12,BI_In) <+ V(E12,BI_In)/roff;
					end
					3'b100: begin
						I(E32,BI_Ip) <+ V(E32,BI_Ip)/ron;
						I(E02,BI_Vp) <+ V(E02,BI_Vp)/ron;
						I(E32,BI_Vn) <+ V(E32,BI_Vn)/ron;
						I(E22,BI_In) <+ V(E22,BI_In)/ron;
						I(E12,BI_In) <+ V(E12,BI_In)/roff;
					end
				endcase
						I(E01,BI_Ip) <+ V(E01,BI_Ip)/roff;
						I(E11,BI_Vp) <+ V(E11,BI_Vp)/roff;
						I(E21,BI_Vn) <+ V(E21,BI_Vn)/roff;
						I(E31,BI_In) <+ V(E31,BI_In)/roff;
						I(E00,BI_Ip) <+ V(E00,BI_Ip)/roff;
						I(E10,BI_Vp) <+ V(E10,BI_Vp)/roff;
						I(E20,BI_Vn) <+ V(E20,BI_Vn)/roff;
						I(E30,BI_In) <+ V(E30,BI_In)/roff;
						I(E03,BI_Ip) <+ V(E03,BI_Ip)/roff;
						I(E13,BI_Vp) <+ V(E13,BI_Vp)/roff;
						I(E23,BI_Vn) <+ V(E23,BI_Vn)/roff;
						I(E33,BI_In) <+ V(E33,BI_In)/roff;
			end
			2'b11: begin
				case(SenseMode)
					3'b000: begin
						I(E03,BI_Ip) <+ V(E03,BI_Ip)/ron;
						I(E13,BI_Vp) <+ V(E13,BI_Vp)/ron;
						I(E23,BI_Vn) <+ V(E23,BI_Vn)/ron;
						I(E33,BI_In) <+ V(E33,BI_In)/ron;
					end
					3'b001: begin
						I(E03,BI_Ip) <+ V(E03,BI_Ip)/ron;
						I(E23,BI_Vp) <+ V(E23,BI_Vp)/ron;
						I(E03,BI_Vn) <+ V(E03,BI_Vn)/ron;
						I(E13,BI_In) <+ V(E13,BI_In)/ron;
						I(E33,BI_In) <+ V(E33,BI_In)*roff;
					end
					3'b010: begin
						I(E13,BI_Ip) <+ V(E13,BI_Ip)/ron;
						I(E23,BI_Vp) <+ V(E23,BI_Vp)/ron;
						I(E13,BI_Vn) <+ V(E13,BI_Vn)/ron;
						I(E03,BI_In) <+ V(E03,BI_In)/ron;
						I(E33,BI_In) <+ V(E33,BI_In)/roff;
					end
					3'b011: begin
						I(E23,BI_Ip) <+ V(E23,BI_Ip)/ron;
						I(E03,BI_Vp) <+ V(E03,BI_Vp)/ron;
						I(E23,BI_Vn) <+ V(E23,BI_Vn)/ron;
						I(E13,BI_In) <+ V(E13,BI_In)/ron;
						I(E13,BI_In) <+ V(E13,BI_In)/roff;
					end
					3'b100: begin
						I(E33,BI_Ip) <+ V(E33,BI_Ip)/ron;
						I(E03,BI_Vp) <+ V(E03,BI_Vp)/ron;
						I(E33,BI_Vn) <+ V(E33,BI_Vn)/ron;
						I(E23,BI_In) <+ V(E23,BI_In)/ron;
						I(E13,BI_In) <+ V(E13,BI_In)/roff;
					end
				endcase
						I(E01,BI_Ip) <+ V(E01,BI_Ip)/roff;
						I(E11,BI_Vp) <+ V(E11,BI_Vp)/roff;
						I(E21,BI_Vn) <+ V(E21,BI_Vn)/roff;
						I(E31,BI_In) <+ V(E31,BI_In)/roff;
						I(E02,BI_Ip) <+ V(E02,BI_Ip)/roff;
						I(E12,BI_Vp) <+ V(E12,BI_Vp)/roff;
						I(E22,BI_Vn) <+ V(E22,BI_Vn)/roff;
						I(E32,BI_In) <+ V(E32,BI_In)/roff;
						I(E00,BI_Ip) <+ V(E00,BI_Ip)/roff;
						I(E10,BI_Vp) <+ V(E10,BI_Vp)/roff;
						I(E20,BI_Vn) <+ V(E20,BI_Vn)/roff;
						I(E30,BI_In) <+ V(E30,BI_In)/roff;
			end
		endcase
	end
end

endmodule
