ADE simulation setup
Run mode: Single Run, Sweeps and Corners
Tests:
  BioZ_EMG_Model:BioZ_AFE_DTBPSDM_diff_opamp_TB:1: BioZ_EMG_Model/BioZ_AFE_DTBPSDM_diff_opamp_TB/config, simulator ams
    Outputs: VT(""); vin_trans; "/voutp"; "/voutn"; (VT("/sum1p") - VT("/sum1n")); vout_trans; noise; "/vinp1"; /vinn; "/vinp"; /vinp; /voutp1; /voutn1; "/voutp_vams"; "/voutn_vams"; gain_dB_vams_amp; phase_vams_amp; GBW_vams_amp; PM_vams_amp; "/voutp_mos_ac"; BW_vams_amp; gain_vams_amp; gain_mos_ac_amp; gain_dB_mos_ac_amp; phase_mos_ac_amp; GBW_mos_ac_amp; PM_mos_ac_amp; BW_mos_ac_amp; gain_vams_int; gain_dB_vams_int; phase_vams_int; GBW_vams_int; PM_vams_int; BW_vams_int; gain_mos_ac_int; gain_dB_mos_ac_int; phase_mos_ac_int; GBW_mos_ac_int; PM_mos_ac_int; BW_mos_ac_int; vout_trans_vams_amp; vout_trans_mos_ac_amp; gain_mos_ac_int2; gain_dB_mos_ac_int2; phase_mos_ac_int2; BW_mos_ac_int2; GBW_mos_ac_int2; PM_mos_ac_int2; /voutp_mos_ac_int2; /voutn_mos_ac_int2
Global variables:
  t_trans = 5m
  vcm = 0.9
  vpk = 0.8
  fs = 62.5k
  f0 = fs/4
  fB = fs/(2*256)
  Av_dB = 71.39
  Av = 10**(Av_dB/20)
  BW = fs/4
  SR = 2*3.1416*Av*BW*1.8
  Cf = 30p
  b1 = 0.49
  Roff = 500M
  Ron = 10
  Rout_ac = 100
  tf = 20n
  tr = 20n
  rf = 150k
  wp2 = 750k
  wz = 5M
