ADE simulation setup
Run mode: Single Run, Sweeps and Corners
Tests:
  BioZ_EMG_Model:BioZ_SigGen_noFilter_TB:1: BioZ_EMG_Model/BioZ_SigGen_noFilter_TB/config, simulator ams
    Outputs: "/I19/IoutP"; "/I19/IoutN"; Iout_TCA_trans; /I19/IoutP; /I19/IoutN
Global variables:
  t_meas = 32.77m
  Ibias = 10u
