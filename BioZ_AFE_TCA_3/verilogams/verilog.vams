//Verilog-AMS HDL for "BioZ_EMG_Model", "BioZ_AFE_TCA" "verilogams"

`include "constants.vams"
`include "disciplines.vams"

module BioZ_AFE_TCA_3 ( bias_CMFB, bias_in, G0, IoutN_1, IoutP_1, IoutN_2, IoutP_2, IoutN_3, IoutP_3, IoutN_4, IoutP_4, VIN_N, VIN_P, vdda, vddd, vssa, vssd, vsub );

input vsub;
inout IoutP_1;
inout IoutP_2;
inout IoutP_3;
inout IoutP_4;
input G0;
inout VIN_P;
inout VIN_N;
input vssd;
input vdda;
inout IoutN_1;
inout IoutN_2;
inout IoutN_3;
inout IoutN_4;
input bias_in;
input vssa;
input vddd;
input bias_CMFB;

logic G0;
electrical VIN_N, VIN_P, VIN_N_n, VIN_P_n, IoutN_1, IoutP_1, IoutN_2, IoutP_2, IoutN_3, IoutP_3, IoutN_4, IoutP_4, vssa;
electrical bias_CMFB;

parameter real fc = 40k from (0:2M];
parameter real vcm = 0.9; //Common mode voltage
parameter real Av = 20000; //DC voltage Gain
parameter real I_bias_CMFB = 0.5u; //Bias current
parameter real GM0 = 6.66666u; //Transconductance Gain
parameter real ip3 = 20;// 3rd order intercept point in dBm

parameter real RS = 10; //Source Resistance
parameter real CS = 3e-7; //Source Capacitance

real GM; //Transconductance
real Gout, Gout_se, vodif; //Output admitance, Output admitance single ended, Output differential voltage
real c, ip, Vin, Voutmax, Vinmax, Vout;

integer analog_state = 0; // Used to communicate between dig and analog!

// Digital control block
always @(G0) begin
	if (G0 == 0) begin
		GM = GM0/4;
	end else begin
		GM = 3*GM0;
	end

	Gout=GM/Av;  //Gout differential
	Gout_se = 2*Gout; //Gout single ended
end

// Analog block
analog begin

	@(initial_step) begin
		//Nonlinearity Model
		c = Av*(4/3)/(pow(10,ip3/10)*2*RS*0.001);

		// Compute the critical point
		Vinmax = sqrt(Av/(3*c));
		Voutmax = (2*Av/3)*Vinmax;
	end

	// Assign the input voltage to the variable, Vin
	Vin = V(VIN_P_n,VIN_N_n);

	// Apply the third order nonlinearity. Clamp the output for extreme inputs
	if (abs(Vin) < Vinmax )
		vodif = (Av - c*Vin*Vin)*Vin;
	else if (Vin > 0)
		vodif = Voutmax;
	else
		vodif = -Voutmax;

    //Amplifier Ouput current
	I(IoutP_1,vssa) <+ laplace_np((V(IoutP_1,vssa)-(vcm+vodif/2))*Gout_se,{1},{-`M_TWO_PI*fc,0});
	I(IoutN_1,vssa) <+ laplace_np((V(IoutN_1,vssa)-(vcm-vodif/2))*Gout_se,{1},{-`M_TWO_PI*fc,0});

	I(IoutP_2,vssa) <+ laplace_np((V(IoutP_2,vssa)-(vcm+vodif/2))*Gout_se,{1},{-`M_TWO_PI*fc,0});
	I(IoutN_2,vssa) <+ laplace_np((V(IoutN_2,vssa)-(vcm-vodif/2))*Gout_se,{1},{-`M_TWO_PI*fc,0});

	I(IoutP_3,vssa) <+ laplace_np((V(IoutP_3,vssa)-(vcm+vodif/2))*Gout_se,{1},{-`M_TWO_PI*fc,0});
	I(IoutN_3,vssa) <+ laplace_np((V(IoutN_3,vssa)-(vcm-vodif/2))*Gout_se,{1},{-`M_TWO_PI*fc,0});

	I(IoutP_4,vssa) <+ laplace_np((V(IoutP_4,vssa)-(vcm+vodif/2))*Gout_se,{1},{-`M_TWO_PI*fc,0});
	I(IoutN_4,vssa) <+ laplace_np((V(IoutN_4,vssa)-(vcm-vodif/2))*Gout_se,{1},{-`M_TWO_PI*fc,0});

	//Noise model
	V(VIN_P_n,VIN_N_n) <+ V(VIN_P,VIN_N) + noise_table("/home/fernande/cadence/workingdir/BioZ_EMG_Model/BioZ_TCA_noise_table", "TCA_noise");

	//Biasing for other stages
//    I(bias_CMFB) <+ -I_bias_CMFB;

end

endmodule
