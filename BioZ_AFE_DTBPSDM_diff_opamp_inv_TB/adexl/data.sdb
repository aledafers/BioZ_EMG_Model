ADE simulation setup
Run mode: Single Run, Sweeps and Corners
Tests:
  BioZ_EMG_Model:BioZ_AFE_DTBPSDM_diff_opamp_inv_TB:1: BioZ_EMG_Model/BioZ_AFE_DTBPSDM_diff_opamp_inv_TB/schematic, simulator spectre
    Outputs: nil; Gain_dB
Global variables:
  vdda = 0.8
  vbias1 = 0.15
  vbias2 = 0.55
  vcm = vdda/2
  ln = 500n
  lp = ln
  wn = 40u
  wp = 1.6*wn
  ln_c = 500n
  lp_c = ln_c
  wn_c = 100u
  wp_c = wn_c
  ln_b = 180n
  lp_b = ln_b
  wn_b = 40u
  wp_b = wn_b,1.2*wn_b,1.4*wn_b,1.6*wn_b,1.8*wn_b,2*wn_b
