ADE simulation setup
Run mode: Single Run, Sweeps and Corners
Tests:
  BioZ_EMG_Model:BioZ_AFE_CTBPSDM_TB:1: BioZ_EMG_Model/BioZ_AFE_CTBPSDM_TB/config, simulator ams
    Outputs: E; NTF; STF
Global variables:
  t_trans = 263m
  vcm = 0
  vpk = 721m
  pi = 3.141593
  n_bw = 10
  Q = 100
  fs = 62.5k
  f0 = fs/4
  fB = f0/(2*256)
  ws = 2*pi*fs
  w0 = 2*pi*f0
  k1err = 1
  k2err = 1
  k3err = 1
  k4err = 1
  wp1 = n_bw*ws
  wp2 = n_bw*ws
  wp3 = n_bw*ws
  wp4 = n_bw*ws
  bw1_en = 1
  bw2_en = 1
  bw3_en = 1
  bw4_en = 1
