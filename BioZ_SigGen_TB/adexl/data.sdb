ADE simulation setup
Run mode: Single Run, Sweeps and Corners
Tests:
  BioZ_EMG_Model:BioZ_SigGen_TB:1: BioZ_EMG_Model/BioZ_SigGen_TB/config, simulator ams
Global variables:
  t_meas = 49.5m
  Ibias = 5u
