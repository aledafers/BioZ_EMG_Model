ADE simulation setup
Run mode: Single Run, Sweeps and Corners
Tests:
  BioZ_EMG_Model:BioZ_AFE_DTBPSDM_CRFB_N-path_v3_TB:1: BioZ_EMG_Model/BioZ_AFE_DTBPSDM_CRFB_N-path_v5_TB/config, simulator ams
    Outputs: VT(""); SDM_in; res1; res2; SDM_out; vdac; /sum1p; /sum1n; sum1; /compp; /compn; (VT("/sum1p") - VT("/sum1n")); comp; /a1; "/a2"; "/b1"; /b2; /a2; /b1; /c1; /c2
Global variables:
  t_trans = 262.2m
  pi = 3.1416
  Voh = 1.8
  vcm = 900m
  vpk = 0.8
  fs = 62.5k
  f0 = fs/4
  fB = fs/(2*256)
  a1 = 0.1973
  a2 = 0.1435
  b1 = 0.1973
  c1 = 0.1869
  c2 = 2.85
  Cf = 35p
  Ch = Cf/10
  Av1_dB = 70
  Av2_dB = 70
  Av1 = 10**(Av1_dB/20)
  Av2 = 10**(Av2_dB/20)
  BW1 = fs
  BW2 = fs
  GBW1 = Av1*BW1
  GBW2 = Av2*BW2
  SR1 = 2*pi*GBW1*Voh
  SR2 = 2*pi*GBW2*Voh
  tr = 20n
  tf = 20n
  Rdc = 300
  Rac = 100
  Ron = 1
  Roff = 1e9
  Voffp_comp = 0
  Voffn_comp = 0
  tdelay_comp = 0
  BW = fs
